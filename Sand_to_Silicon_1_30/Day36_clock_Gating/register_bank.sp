* SPICE netlist generated by Yosys 0.64+26 (git sha1 a54bca549, clang++ 14.0.0-1ubuntu1.1 -fPIC -O3)

.SUBCKT icg clk en gclk
X0 clk 1 INVX1
X1 clk en_latched gclk AND2X1
X2 1 en en_latched LATCH
.ENDS icg

X0 gclk data_in.13 data_out.13 rst_n Vdd DFFSR
X1 gclk data_in.14 data_out.14 rst_n Vdd DFFSR
X2 gclk data_in.15 data_out.15 rst_n Vdd DFFSR
X3 gclk data_in.16 data_out.16 rst_n Vdd DFFSR
X4 gclk data_in.17 data_out.17 rst_n Vdd DFFSR
X5 gclk data_in.18 data_out.18 rst_n Vdd DFFSR
X6 gclk data_in.19 data_out.19 rst_n Vdd DFFSR
X7 gclk data_in.20 data_out.20 rst_n Vdd DFFSR
X8 gclk data_in.21 data_out.21 rst_n Vdd DFFSR
X9 gclk data_in.22 data_out.22 rst_n Vdd DFFSR
X10 gclk data_in.23 data_out.23 rst_n Vdd DFFSR
X11 gclk data_in.24 data_out.24 rst_n Vdd DFFSR
X12 gclk data_in.25 data_out.25 rst_n Vdd DFFSR
X13 gclk data_in.26 data_out.26 rst_n Vdd DFFSR
X14 gclk data_in.27 data_out.27 rst_n Vdd DFFSR
X15 gclk data_in.28 data_out.28 rst_n Vdd DFFSR
X16 gclk data_in.29 data_out.29 rst_n Vdd DFFSR
X17 gclk data_in.30 data_out.30 rst_n Vdd DFFSR
X18 gclk data_in.31 data_out.31 rst_n Vdd DFFSR
X19 gclk data_in.0 data_out.0 rst_n Vdd DFFSR
X20 gclk data_in.1 data_out.1 rst_n Vdd DFFSR
X21 gclk data_in.2 data_out.2 rst_n Vdd DFFSR
X22 gclk data_in.3 data_out.3 rst_n Vdd DFFSR
X23 gclk data_in.4 data_out.4 rst_n Vdd DFFSR
X24 gclk data_in.5 data_out.5 rst_n Vdd DFFSR
X25 gclk data_in.6 data_out.6 rst_n Vdd DFFSR
X26 gclk data_in.7 data_out.7 rst_n Vdd DFFSR
X27 gclk data_in.8 data_out.8 rst_n Vdd DFFSR
X28 gclk data_in.9 data_out.9 rst_n Vdd DFFSR
X29 gclk data_in.10 data_out.10 rst_n Vdd DFFSR
X30 gclk data_in.11 data_out.11 rst_n Vdd DFFSR
X31 gclk data_in.12 data_out.12 rst_n Vdd DFFSR
X32 clk write_en gclk icg

************************
* end of SPICE netlist *
************************
